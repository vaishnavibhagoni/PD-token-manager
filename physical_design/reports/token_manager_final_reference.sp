* SPICE netlist generated by Yosys 0.47+121 (git sha1 98b4affc4, g++ 13.2.0-23ubuntu4 -fPIC -O3)

X0 clknet_4_1_0_clk _085_ generated_token_7_ sky130_fd_sc_hd__dfxtp_1
X1 clknet_4_4_0_clk _060_ generated_token_6_ sky130_fd_sc_hd__dfxtp_1
X2 clknet_4_1_0_clk _061_ generated_token_5_ sky130_fd_sc_hd__dfxtp_1
X3 clknet_4_4_0_clk _062_ generated_token_4_ sky130_fd_sc_hd__dfxtp_1
X4 clknet_4_1_0_clk _063_ generated_token_3_ sky130_fd_sc_hd__dfxtp_1
X5 clknet_4_4_0_clk _064_ generated_token_2_ sky130_fd_sc_hd__dfxtp_1
X6 clknet_4_1_0_clk _065_ generated_token_1_ sky130_fd_sc_hd__dfxtp_1
X7 clknet_4_1_0_clk _066_ generated_token_0_ sky130_fd_sc_hd__dfxtp_1
X8 clknet_4_7_0_clk _084_ net20 sky130_fd_sc_hd__dfxtp_1
X9 clknet_4_11_0_clk _088_ scheduler.priority_count_1_ sky130_fd_sc_hd__dfxtp_1
X10 clknet_4_14_0_clk _074_ scheduler.priority_count_0_ sky130_fd_sc_hd__dfxtp_1
X11 clknet_4_13_0_clk _090_ priority_q.write_ptr_2_ sky130_fd_sc_hd__dfxtp_1
X12 clknet_4_14_0_clk _080_ priority_q.write_ptr_1_ sky130_fd_sc_hd__dfxtp_1
X13 clknet_4_14_0_clk _081_ priority_q.write_ptr_0_ sky130_fd_sc_hd__dfxtp_1
X14 clknet_4_14_0_clk _082_ priority_q.read_ptr_2_ sky130_fd_sc_hd__dfxtp_1
X15 clknet_4_15_0_clk _078_ priority_q.read_ptr_1_ sky130_fd_sc_hd__dfxtp_1
X16 clknet_4_15_0_clk _079_ priority_q.read_ptr_0_ sky130_fd_sc_hd__dfxtp_1
X17 clknet_4_12_0_clk generated_token_7_ priority_q.memory_7__7_ _107_ sky130_fd_sc_hd__edfxtp_1
X18 clknet_4_1_0_clk generated_token_6_ priority_q.memory_7__6_ _107_ sky130_fd_sc_hd__edfxtp_1
X19 clknet_4_4_0_clk generated_token_5_ priority_q.memory_7__5_ _107_ sky130_fd_sc_hd__edfxtp_1
X20 clknet_4_4_0_clk generated_token_4_ priority_q.memory_7__4_ _107_ sky130_fd_sc_hd__edfxtp_1
X21 clknet_4_4_0_clk generated_token_3_ priority_q.memory_7__3_ _107_ sky130_fd_sc_hd__edfxtp_1
X22 clknet_4_12_0_clk generated_token_2_ priority_q.memory_7__2_ _107_ sky130_fd_sc_hd__edfxtp_1
X23 clknet_4_12_0_clk generated_token_1_ priority_q.memory_7__1_ _107_ sky130_fd_sc_hd__edfxtp_1
X24 clknet_4_6_0_clk generated_token_0_ priority_q.memory_7__0_ _107_ sky130_fd_sc_hd__edfxtp_1
X25 clknet_4_13_0_clk generated_token_7_ priority_q.memory_6__7_ net32 sky130_fd_sc_hd__edfxtp_1
X26 clknet_4_4_0_clk generated_token_6_ priority_q.memory_6__6_ net32 sky130_fd_sc_hd__edfxtp_1
X27 clknet_4_4_0_clk generated_token_5_ priority_q.memory_6__5_ net32 sky130_fd_sc_hd__edfxtp_1
X28 clknet_4_4_0_clk generated_token_4_ priority_q.memory_6__4_ net32 sky130_fd_sc_hd__edfxtp_1
X29 clknet_4_4_0_clk generated_token_3_ priority_q.memory_6__3_ net32 sky130_fd_sc_hd__edfxtp_1
X30 clknet_4_12_0_clk generated_token_2_ priority_q.memory_6__2_ net32 sky130_fd_sc_hd__edfxtp_1
X31 clknet_4_12_0_clk generated_token_1_ priority_q.memory_6__1_ net32 sky130_fd_sc_hd__edfxtp_1
X32 clknet_4_6_0_clk generated_token_0_ priority_q.memory_6__0_ net32 sky130_fd_sc_hd__edfxtp_1
X33 clknet_4_6_0_clk generated_token_7_ priority_q.memory_5__7_ _105_ sky130_fd_sc_hd__edfxtp_1
X34 clknet_4_6_0_clk generated_token_6_ priority_q.memory_5__6_ _105_ sky130_fd_sc_hd__edfxtp_1
X35 clknet_4_6_0_clk generated_token_5_ priority_q.memory_5__5_ _105_ sky130_fd_sc_hd__edfxtp_1
X36 clknet_4_6_0_clk generated_token_4_ priority_q.memory_5__4_ _105_ sky130_fd_sc_hd__edfxtp_1
X37 clknet_4_6_0_clk generated_token_3_ priority_q.memory_5__3_ _105_ sky130_fd_sc_hd__edfxtp_1
X38 clknet_4_6_0_clk generated_token_2_ priority_q.memory_5__2_ _105_ sky130_fd_sc_hd__edfxtp_1
X39 clknet_4_6_0_clk generated_token_1_ priority_q.memory_5__1_ _105_ sky130_fd_sc_hd__edfxtp_1
X40 clknet_4_6_0_clk generated_token_0_ priority_q.memory_5__0_ _105_ sky130_fd_sc_hd__edfxtp_1
X41 clknet_4_12_0_clk generated_token_7_ priority_q.memory_4__7_ _104_ sky130_fd_sc_hd__edfxtp_1
X42 clknet_4_1_0_clk generated_token_6_ priority_q.memory_4__6_ _104_ sky130_fd_sc_hd__edfxtp_1
X43 clknet_4_4_0_clk generated_token_5_ priority_q.memory_4__5_ _104_ sky130_fd_sc_hd__edfxtp_1
X44 clknet_4_4_0_clk generated_token_4_ priority_q.memory_4__4_ _104_ sky130_fd_sc_hd__edfxtp_1
X45 clknet_4_5_0_clk generated_token_3_ priority_q.memory_4__3_ _104_ sky130_fd_sc_hd__edfxtp_1
X46 clknet_4_12_0_clk generated_token_2_ priority_q.memory_4__2_ _104_ sky130_fd_sc_hd__edfxtp_1
X47 clknet_4_12_0_clk generated_token_1_ priority_q.memory_4__1_ _104_ sky130_fd_sc_hd__edfxtp_1
X48 clknet_4_6_0_clk generated_token_0_ priority_q.memory_4__0_ _104_ sky130_fd_sc_hd__edfxtp_1
X49 clknet_4_7_0_clk generated_token_7_ priority_q.memory_3__7_ _103_ sky130_fd_sc_hd__edfxtp_1
X50 clknet_4_7_0_clk generated_token_6_ priority_q.memory_3__6_ _103_ sky130_fd_sc_hd__edfxtp_1
X51 clknet_4_7_0_clk generated_token_5_ priority_q.memory_3__5_ _103_ sky130_fd_sc_hd__edfxtp_1
X52 clknet_4_7_0_clk generated_token_4_ priority_q.memory_3__4_ _103_ sky130_fd_sc_hd__edfxtp_1
X53 clknet_4_7_0_clk generated_token_3_ priority_q.memory_3__3_ _103_ sky130_fd_sc_hd__edfxtp_1
X54 clknet_4_7_0_clk generated_token_2_ priority_q.memory_3__2_ _103_ sky130_fd_sc_hd__edfxtp_1
X55 clknet_4_7_0_clk generated_token_1_ priority_q.memory_3__1_ _103_ sky130_fd_sc_hd__edfxtp_1
X56 clknet_4_7_0_clk generated_token_0_ priority_q.memory_3__0_ _103_ sky130_fd_sc_hd__edfxtp_1
X57 clknet_4_13_0_clk generated_token_7_ priority_q.memory_2__7_ _102_ sky130_fd_sc_hd__edfxtp_1
X58 clknet_4_5_0_clk generated_token_6_ priority_q.memory_2__6_ _102_ sky130_fd_sc_hd__edfxtp_1
X59 clknet_4_5_0_clk generated_token_5_ priority_q.memory_2__5_ _102_ sky130_fd_sc_hd__edfxtp_1
X60 clknet_4_5_0_clk generated_token_4_ priority_q.memory_2__4_ _102_ sky130_fd_sc_hd__edfxtp_1
X61 clknet_4_5_0_clk generated_token_3_ priority_q.memory_2__3_ _102_ sky130_fd_sc_hd__edfxtp_1
X62 clknet_4_7_0_clk generated_token_2_ priority_q.memory_2__2_ _102_ sky130_fd_sc_hd__edfxtp_1
X63 clknet_4_13_0_clk generated_token_1_ priority_q.memory_2__1_ _102_ sky130_fd_sc_hd__edfxtp_1
X64 clknet_4_7_0_clk generated_token_0_ priority_q.memory_2__0_ _102_ sky130_fd_sc_hd__edfxtp_1
X65 clknet_4_13_0_clk generated_token_7_ priority_q.memory_1__7_ _101_ sky130_fd_sc_hd__edfxtp_1
X66 clknet_4_5_0_clk generated_token_6_ priority_q.memory_1__6_ _101_ sky130_fd_sc_hd__edfxtp_1
X67 clknet_4_5_0_clk generated_token_5_ priority_q.memory_1__5_ _101_ sky130_fd_sc_hd__edfxtp_1
X68 clknet_4_5_0_clk generated_token_4_ priority_q.memory_1__4_ _101_ sky130_fd_sc_hd__edfxtp_1
X69 clknet_4_5_0_clk generated_token_3_ priority_q.memory_1__3_ _101_ sky130_fd_sc_hd__edfxtp_1
X70 clknet_4_7_0_clk generated_token_2_ priority_q.memory_1__2_ _101_ sky130_fd_sc_hd__edfxtp_1
X71 clknet_4_13_0_clk generated_token_1_ priority_q.memory_1__1_ _101_ sky130_fd_sc_hd__edfxtp_1
X72 clknet_4_7_0_clk generated_token_0_ priority_q.memory_1__0_ _101_ sky130_fd_sc_hd__edfxtp_1
X73 clknet_4_13_0_clk generated_token_7_ priority_q.memory_0__7_ net29 sky130_fd_sc_hd__edfxtp_1
X74 clknet_4_5_0_clk generated_token_6_ priority_q.memory_0__6_ net29 sky130_fd_sc_hd__edfxtp_1
X75 clknet_4_5_0_clk generated_token_5_ priority_q.memory_0__5_ net29 sky130_fd_sc_hd__edfxtp_1
X76 clknet_4_5_0_clk generated_token_4_ priority_q.memory_0__4_ net29 sky130_fd_sc_hd__edfxtp_1
X77 clknet_4_5_0_clk generated_token_3_ priority_q.memory_0__3_ net29 sky130_fd_sc_hd__edfxtp_1
X78 clknet_4_13_0_clk generated_token_2_ priority_q.memory_0__2_ net29 sky130_fd_sc_hd__edfxtp_1
X79 clknet_4_13_0_clk generated_token_1_ priority_q.memory_0__1_ net29 sky130_fd_sc_hd__edfxtp_1
X80 clknet_4_7_0_clk generated_token_0_ priority_q.memory_0__0_ net29 sky130_fd_sc_hd__edfxtp_1
X81 clknet_4_15_0_clk _089_ priority_count_3_ sky130_fd_sc_hd__dfxtp_1
X82 clknet_4_15_0_clk _075_ priority_count_2_ sky130_fd_sc_hd__dfxtp_1
X83 clknet_4_15_0_clk _076_ priority_count_1_ sky130_fd_sc_hd__dfxtp_1
X84 clknet_4_15_0_clk _077_ priority_count_0_ sky130_fd_sc_hd__dfxtp_1
X85 net3 net34 sky130_fd_sc_hd__buf_4
X86 _097_ net33 sky130_fd_sc_hd__buf_4
X87 _106_ net32 sky130_fd_sc_hd__buf_4
X88 _095_ net31 sky130_fd_sc_hd__buf_4
X89 _093_ net30 sky130_fd_sc_hd__buf_4
X90 _100_ net29 sky130_fd_sc_hd__buf_4
X91 _096_ net28 sky130_fd_sc_hd__buf_4
X92 _094_ net27 sky130_fd_sc_hd__buf_4
X93 _092_ net26 sky130_fd_sc_hd__buf_4
X94 net9 current_token.4 sky130_fd_sc_hd__clkdlybuf4s50_1
X95 net8 current_token.3 sky130_fd_sc_hd__clkdlybuf4s50_1
X96 net7 current_token.2 sky130_fd_sc_hd__clkdlybuf4s50_1
X97 net6 current_token.1 sky130_fd_sc_hd__clkdlybuf4s50_1
X98 net5 current_token.0 sky130_fd_sc_hd__clkdlybuf4s50_1
X99 net20 service_complete sky130_fd_sc_hd__clkdlybuf4s50_1
X100 net19 queue_full sky130_fd_sc_hd__clkdlybuf4s50_1
X101 net18 queue_count.4 sky130_fd_sc_hd__clkdlybuf4s50_1
X102 net17 queue_count.3 sky130_fd_sc_hd__clkdlybuf4s50_1
X103 net16 queue_count.2 sky130_fd_sc_hd__clkdlybuf4s50_1
X104 net15 queue_count.1 sky130_fd_sc_hd__clkdlybuf4s50_1
X105 net14 queue_count.0 sky130_fd_sc_hd__clkdlybuf4s50_1
X106 net13 priority_active sky130_fd_sc_hd__clkdlybuf4s50_1
X107 net12 current_token.7 sky130_fd_sc_hd__clkdlybuf4s50_1
X108 net11 current_token.6 sky130_fd_sc_hd__clkdlybuf4s50_1
X109 net10 current_token.5 sky130_fd_sc_hd__clkdlybuf4s50_1
X110 clknet_4_9_0_clk _087_ normal_q.write_ptr_2_ sky130_fd_sc_hd__dfxtp_1
X111 clknet_4_9_0_clk _072_ normal_q.write_ptr_1_ sky130_fd_sc_hd__dfxtp_1
X112 clknet_4_9_0_clk _073_ normal_q.write_ptr_0_ sky130_fd_sc_hd__dfxtp_1
X113 clknet_4_10_0_clk _083_ normal_q.read_ptr_2_ sky130_fd_sc_hd__dfxtp_1
X114 clknet_4_11_0_clk _070_ normal_q.read_ptr_1_ sky130_fd_sc_hd__dfxtp_1
X115 clknet_4_11_0_clk _071_ normal_q.read_ptr_0_ sky130_fd_sc_hd__dfxtp_1
X116 clknet_4_10_0_clk generated_token_7_ normal_q.memory_7__7_ _099_ sky130_fd_sc_hd__edfxtp_1
X117 clknet_4_0_0_clk generated_token_6_ normal_q.memory_7__6_ _099_ sky130_fd_sc_hd__edfxtp_1
X118 clknet_4_0_0_clk generated_token_5_ normal_q.memory_7__5_ _099_ sky130_fd_sc_hd__edfxtp_1
X119 clknet_4_1_0_clk generated_token_4_ normal_q.memory_7__4_ _099_ sky130_fd_sc_hd__edfxtp_1
X120 clknet_4_0_0_clk generated_token_3_ normal_q.memory_7__3_ _099_ sky130_fd_sc_hd__edfxtp_1
X121 clknet_4_8_0_clk generated_token_2_ normal_q.memory_7__2_ _099_ sky130_fd_sc_hd__edfxtp_1
X122 clknet_4_8_0_clk generated_token_1_ normal_q.memory_7__1_ _099_ sky130_fd_sc_hd__edfxtp_1
X123 clknet_4_2_0_clk generated_token_0_ normal_q.memory_7__0_ _099_ sky130_fd_sc_hd__edfxtp_1
X124 clknet_4_9_0_clk generated_token_7_ normal_q.memory_6__7_ _098_ sky130_fd_sc_hd__edfxtp_1
X125 clknet_4_3_0_clk generated_token_6_ normal_q.memory_6__6_ _098_ sky130_fd_sc_hd__edfxtp_1
X126 clknet_4_2_0_clk generated_token_5_ normal_q.memory_6__5_ _098_ sky130_fd_sc_hd__edfxtp_1
X127 clknet_4_3_0_clk generated_token_4_ normal_q.memory_6__4_ _098_ sky130_fd_sc_hd__edfxtp_1
X128 clknet_4_2_0_clk generated_token_3_ normal_q.memory_6__3_ _098_ sky130_fd_sc_hd__edfxtp_1
X129 clknet_4_2_0_clk generated_token_2_ normal_q.memory_6__2_ _098_ sky130_fd_sc_hd__edfxtp_1
X130 clknet_4_8_0_clk generated_token_1_ normal_q.memory_6__1_ _098_ sky130_fd_sc_hd__edfxtp_1
X131 clknet_4_3_0_clk generated_token_0_ normal_q.memory_6__0_ _098_ sky130_fd_sc_hd__edfxtp_1
X132 clknet_4_10_0_clk generated_token_7_ normal_q.memory_5__7_ net33 sky130_fd_sc_hd__edfxtp_1
X133 clknet_4_1_0_clk generated_token_6_ normal_q.memory_5__6_ net33 sky130_fd_sc_hd__edfxtp_1
X134 clknet_4_0_0_clk generated_token_5_ normal_q.memory_5__5_ net33 sky130_fd_sc_hd__edfxtp_1
X135 clknet_4_1_0_clk generated_token_4_ normal_q.memory_5__4_ net33 sky130_fd_sc_hd__edfxtp_1
X136 clknet_4_0_0_clk generated_token_3_ normal_q.memory_5__3_ net33 sky130_fd_sc_hd__edfxtp_1
X137 clknet_4_9_0_clk generated_token_2_ normal_q.memory_5__2_ net33 sky130_fd_sc_hd__edfxtp_1
X138 clknet_4_8_0_clk generated_token_1_ normal_q.memory_5__1_ net33 sky130_fd_sc_hd__edfxtp_1
X139 clknet_4_3_0_clk generated_token_0_ normal_q.memory_5__0_ net33 sky130_fd_sc_hd__edfxtp_1
X140 clknet_4_9_0_clk generated_token_7_ normal_q.memory_4__7_ net28 sky130_fd_sc_hd__edfxtp_1
X141 clknet_4_3_0_clk generated_token_6_ normal_q.memory_4__6_ net28 sky130_fd_sc_hd__edfxtp_1
X142 clknet_4_2_0_clk generated_token_5_ normal_q.memory_4__5_ net28 sky130_fd_sc_hd__edfxtp_1
X143 clknet_4_3_0_clk generated_token_4_ normal_q.memory_4__4_ net28 sky130_fd_sc_hd__edfxtp_1
X144 clknet_4_2_0_clk generated_token_3_ normal_q.memory_4__3_ net28 sky130_fd_sc_hd__edfxtp_1
X145 clknet_4_2_0_clk generated_token_2_ normal_q.memory_4__2_ net28 sky130_fd_sc_hd__edfxtp_1
X146 clknet_4_8_0_clk generated_token_1_ normal_q.memory_4__1_ net28 sky130_fd_sc_hd__edfxtp_1
X147 clknet_4_9_0_clk generated_token_0_ normal_q.memory_4__0_ net28 sky130_fd_sc_hd__edfxtp_1
X148 clknet_4_8_0_clk generated_token_7_ normal_q.memory_3__7_ net31 sky130_fd_sc_hd__edfxtp_1
X149 clknet_4_0_0_clk generated_token_6_ normal_q.memory_3__6_ net31 sky130_fd_sc_hd__edfxtp_1
X150 clknet_4_0_0_clk generated_token_5_ normal_q.memory_3__5_ net31 sky130_fd_sc_hd__edfxtp_1
X151 clknet_4_0_0_clk generated_token_4_ normal_q.memory_3__4_ net31 sky130_fd_sc_hd__edfxtp_1
X152 clknet_4_0_0_clk generated_token_3_ normal_q.memory_3__3_ net31 sky130_fd_sc_hd__edfxtp_1
X153 clknet_4_2_0_clk generated_token_2_ normal_q.memory_3__2_ net31 sky130_fd_sc_hd__edfxtp_1
X154 clknet_4_10_0_clk generated_token_1_ normal_q.memory_3__1_ net31 sky130_fd_sc_hd__edfxtp_1
X155 clknet_4_2_0_clk generated_token_0_ normal_q.memory_3__0_ net31 sky130_fd_sc_hd__edfxtp_1
X156 clknet_4_9_0_clk generated_token_7_ normal_q.memory_2__7_ net27 sky130_fd_sc_hd__edfxtp_1
X157 clknet_4_1_0_clk generated_token_6_ normal_q.memory_2__6_ net27 sky130_fd_sc_hd__edfxtp_1
X158 clknet_4_2_0_clk generated_token_5_ normal_q.memory_2__5_ net27 sky130_fd_sc_hd__edfxtp_1
X159 clknet_4_3_0_clk generated_token_4_ normal_q.memory_2__4_ net27 sky130_fd_sc_hd__edfxtp_1
X160 clknet_4_2_0_clk generated_token_3_ normal_q.memory_2__3_ net27 sky130_fd_sc_hd__edfxtp_1
X161 clknet_4_2_0_clk generated_token_2_ normal_q.memory_2__2_ net27 sky130_fd_sc_hd__edfxtp_1
X162 clknet_4_8_0_clk generated_token_1_ normal_q.memory_2__1_ net27 sky130_fd_sc_hd__edfxtp_1
X163 clknet_4_3_0_clk generated_token_0_ normal_q.memory_2__0_ net27 sky130_fd_sc_hd__edfxtp_1
X164 clknet_4_10_0_clk generated_token_7_ normal_q.memory_1__7_ net30 sky130_fd_sc_hd__edfxtp_1
X165 clknet_4_0_0_clk generated_token_6_ normal_q.memory_1__6_ net30 sky130_fd_sc_hd__edfxtp_1
X166 clknet_4_0_0_clk generated_token_5_ normal_q.memory_1__5_ net30 sky130_fd_sc_hd__edfxtp_1
X167 clknet_4_1_0_clk generated_token_4_ normal_q.memory_1__4_ net30 sky130_fd_sc_hd__edfxtp_1
X168 clknet_4_0_0_clk generated_token_3_ normal_q.memory_1__3_ net30 sky130_fd_sc_hd__edfxtp_1
X169 clknet_4_2_0_clk generated_token_2_ normal_q.memory_1__2_ net30 sky130_fd_sc_hd__edfxtp_1
X170 clknet_4_10_0_clk generated_token_1_ normal_q.memory_1__1_ net30 sky130_fd_sc_hd__edfxtp_1
X171 clknet_4_2_0_clk generated_token_0_ normal_q.memory_1__0_ net30 sky130_fd_sc_hd__edfxtp_1
X172 clknet_4_9_0_clk generated_token_7_ normal_q.memory_0__7_ net26 sky130_fd_sc_hd__edfxtp_1
X173 clknet_4_1_0_clk generated_token_6_ normal_q.memory_0__6_ net26 sky130_fd_sc_hd__edfxtp_1
X174 clknet_4_2_0_clk generated_token_5_ normal_q.memory_0__5_ net26 sky130_fd_sc_hd__edfxtp_1
X175 clknet_4_3_0_clk generated_token_4_ normal_q.memory_0__4_ net26 sky130_fd_sc_hd__edfxtp_1
X176 clknet_4_2_0_clk generated_token_3_ normal_q.memory_0__3_ net26 sky130_fd_sc_hd__edfxtp_1
X177 clknet_4_2_0_clk generated_token_2_ normal_q.memory_0__2_ net26 sky130_fd_sc_hd__edfxtp_1
X178 clknet_4_8_0_clk generated_token_1_ normal_q.memory_0__1_ net26 sky130_fd_sc_hd__edfxtp_1
X179 clknet_4_2_0_clk generated_token_0_ normal_q.memory_0__0_ net26 sky130_fd_sc_hd__edfxtp_1
X180 clknet_4_11_0_clk _086_ normal_count_3_ sky130_fd_sc_hd__dfxtp_1
X181 clknet_4_11_0_clk _067_ normal_count_2_ sky130_fd_sc_hd__dfxtp_1
X182 clknet_4_11_0_clk _068_ normal_count_1_ sky130_fd_sc_hd__dfxtp_1
X183 clknet_4_11_0_clk _069_ normal_count_0_ sky130_fd_sc_hd__dfxtp_1
X184 serve_next net4 sky130_fd_sc_hd__clkdlybuf4s50_1
X185 reset net3 sky130_fd_sc_hd__buf_2
X186 priority_token net2 sky130_fd_sc_hd__clkdlybuf4s50_1
X187 new_token net1 sky130_fd_sc_hd__clkdlybuf4s50_1
X188 clknet_4_14_0_clk _091_ net12 sky130_fd_sc_hd__dfxtp_1
X189 clknet_4_12_0_clk _053_ net11 sky130_fd_sc_hd__dfxtp_1
X190 clknet_4_3_0_clk _054_ net10 sky130_fd_sc_hd__dfxtp_1
X191 clknet_4_3_0_clk _055_ net9 sky130_fd_sc_hd__dfxtp_1
X192 clknet_4_9_0_clk _056_ net8 sky130_fd_sc_hd__dfxtp_1
X193 clknet_4_12_0_clk _057_ net7 sky130_fd_sc_hd__dfxtp_1
X194 clknet_4_11_0_clk _058_ net6 sky130_fd_sc_hd__dfxtp_1
X195 clknet_4_9_0_clk _059_ net5 sky130_fd_sc_hd__dfxtp_1
X196 clknet_4_10_0_clk _NC0 sky130_fd_sc_hd__clkinv_8
X197 clknet_4_9_0_clk _NC1 sky130_fd_sc_hd__inv_6
X198 clknet_4_8_0_clk _NC2 sky130_fd_sc_hd__inv_8
X199 clknet_4_7_0_clk _NC3 sky130_fd_sc_hd__bufinv_16
X200 clknet_4_6_0_clk _NC4 sky130_fd_sc_hd__inv_6
X201 clknet_4_5_0_clk _NC5 sky130_fd_sc_hd__clkinvlp_4
X202 clknet_4_4_0_clk _NC6 sky130_fd_sc_hd__clkinv_4
X203 clknet_4_3_0_clk _NC7 sky130_fd_sc_hd__inv_6
X204 clknet_4_15_0_clk _NC8 sky130_fd_sc_hd__inv_8
X205 clknet_4_14_0_clk _NC9 sky130_fd_sc_hd__clkinv_8
X206 clknet_4_13_0_clk _NC10 sky130_fd_sc_hd__inv_8
X207 clknet_4_12_0_clk _NC11 sky130_fd_sc_hd__inv_6
X208 clknet_4_11_0_clk _NC12 sky130_fd_sc_hd__inv_6
X209 clknet_4_1_0_clk _NC13 sky130_fd_sc_hd__clkinvlp_4
X210 clknet_4_0_0_clk _NC14 sky130_fd_sc_hd__clkinv_4
X211 clknet_0_clk clknet_4_9_0_clk sky130_fd_sc_hd__clkbuf_16
X212 clknet_0_clk clknet_4_8_0_clk sky130_fd_sc_hd__clkbuf_16
X213 clknet_0_clk clknet_4_7_0_clk sky130_fd_sc_hd__clkbuf_16
X214 clknet_0_clk clknet_4_6_0_clk sky130_fd_sc_hd__clkbuf_16
X215 clknet_0_clk clknet_4_5_0_clk sky130_fd_sc_hd__clkbuf_16
X216 clknet_0_clk clknet_4_4_0_clk sky130_fd_sc_hd__clkbuf_16
X217 clknet_0_clk clknet_4_3_0_clk sky130_fd_sc_hd__clkbuf_16
X218 clknet_0_clk clknet_4_2_0_clk sky130_fd_sc_hd__clkbuf_16
X219 clknet_0_clk clknet_4_1_0_clk sky130_fd_sc_hd__clkbuf_16
X220 clknet_0_clk clknet_4_15_0_clk sky130_fd_sc_hd__clkbuf_16
X221 clknet_0_clk clknet_4_14_0_clk sky130_fd_sc_hd__clkbuf_16
X222 clknet_0_clk clknet_4_13_0_clk sky130_fd_sc_hd__clkbuf_16
X223 clknet_0_clk clknet_4_12_0_clk sky130_fd_sc_hd__clkbuf_16
X224 clknet_0_clk clknet_4_11_0_clk sky130_fd_sc_hd__clkbuf_16
X225 clknet_0_clk clknet_4_10_0_clk sky130_fd_sc_hd__clkbuf_16
X226 clknet_0_clk clknet_4_0_0_clk sky130_fd_sc_hd__clkbuf_16
X227 clk clknet_0_clk sky130_fd_sc_hd__clkbuf_16
X228 clknet_4_10_0_clk _083_ _002_ sky130_fd_sc_hd__dfxtp_1
X229 clknet_4_11_0_clk _070_ _001_ sky130_fd_sc_hd__dfxtp_1
X230 clknet_4_11_0_clk _071_ _000_ sky130_fd_sc_hd__dfxtp_1
X231 clknet_4_14_0_clk _082_ _005_ sky130_fd_sc_hd__dfxtp_1
X232 clknet_4_15_0_clk _078_ _004_ sky130_fd_sc_hd__dfxtp_1
X233 clknet_4_15_0_clk _079_ _003_ sky130_fd_sc_hd__dfxtp_1
X234 priority_count_2_ _013_ _051_ _052_ sky130_fd_sc_hd__ha_1
X235 priority_count_1_ _013_ _050_ _030_ sky130_fd_sc_hd__ha_1
X236 normal_count_2_ priority_count_2_ _048_ _049_ sky130_fd_sc_hd__ha_1
X237 _045_ _046_ _013_ _047_ sky130_fd_sc_hd__ha_1
X238 _042_ _114_ _019_ _044_ sky130_fd_sc_hd__ha_1
X239 normal_count_1_ priority_count_1_ _041_ _024_ sky130_fd_sc_hd__ha_1
X240 scheduler.priority_count_0_ scheduler.priority_count_1_ _039_ _040_ sky130_fd_sc_hd__ha_1
X241 normal_q.read_ptr_0_ normal_q.read_ptr_1_ _037_ _038_ sky130_fd_sc_hd__ha_1
X242 priority_q.write_ptr_0_ priority_q.write_ptr_1_ _035_ _036_ sky130_fd_sc_hd__ha_1
X243 normal_count_2_ _019_ _033_ _034_ sky130_fd_sc_hd__ha_1
X244 priority_q.read_ptr_0_ priority_q.read_ptr_1_ _031_ _032_ sky130_fd_sc_hd__ha_1
X245 generated_token_0_ generated_token_1_ _029_ _279_ sky130_fd_sc_hd__ha_1
X246 generated_token_0_ generated_token_1_ _027_ _028_ sky130_fd_sc_hd__ha_1
X247 normal_q.write_ptr_0_ normal_q.write_ptr_1_ _025_ _026_ sky130_fd_sc_hd__ha_1
X248 normal_count_0_ priority_count_0_ _006_ net14 sky130_fd_sc_hd__ha_1
X249 normal_count_1_ _019_ _022_ _023_ sky130_fd_sc_hd__ha_1
X250 normal_count_3_ priority_count_3_ _020_ _021_ sky130_fd_sc_hd__ha_1
X251 _014_ _015_ _016_ _017_ _018_ sky130_fd_sc_hd__fa_1
X252 _008_ _009_ _010_ _011_ _012_ sky130_fd_sc_hd__fa_1
X253 normal_count_1_ priority_count_1_ _006_ _007_ net15 sky130_fd_sc_hd__fa_1
X254 priority_q.write_ptr_2_ _244_ _103_ priority_q.write_ptr_1_ sky130_fd_sc_hd__nor3b_1
X255 priority_q.write_ptr_2_ _238_ _104_ priority_q.write_ptr_1_ sky130_fd_sc_hd__and3b_1
X256 _116_ _117_ net19 sky130_fd_sc_hd__nand2_1
X257 _091_ _114_ _273_ _274_ _278_ net34 sky130_fd_sc_hd__a2111oi_2
X258 _278_ _005_ _275_ _277_ _111_ sky130_fd_sc_hd__a211oi_2
X259 _005_ _277_ _276_ sky130_fd_sc_hd__nor2b_1
X260 _276_ priority_q.memory_1__7_ priority_q.memory_2__7_ priority_q.memory_3__7_ priority_q.memory_0__7_ _003_ _004_ sky130_fd_sc_hd__mux4_1
X261 _275_ priority_q.memory_5__7_ priority_q.memory_6__7_ priority_q.memory_7__7_ priority_q.memory_4__7_ _003_ _004_ sky130_fd_sc_hd__mux4_1
X262 net12 _128_ _274_ sky130_fd_sc_hd__nor2_1
X263 _000_ _273_ _272_ _271_ sky130_fd_sc_hd__mux2i_1
X264 _272_ normal_q.memory_3__7_ normal_q.memory_5__7_ normal_q.memory_7__7_ normal_q.memory_1__7_ _001_ _002_ sky130_fd_sc_hd__mux4_2
X265 _271_ normal_q.memory_2__7_ normal_q.memory_4__7_ normal_q.memory_6__7_ normal_q.memory_0__7_ _001_ _002_ sky130_fd_sc_hd__mux4_2
X266 _244_ priority_q.write_ptr_1_ _105_ priority_q.write_ptr_2_ sky130_fd_sc_hd__nor3b_1
X267 _238_ priority_q.write_ptr_1_ _102_ priority_q.write_ptr_2_ sky130_fd_sc_hd__and3b_1
X268 priority_count_1_ _009_ sky130_fd_sc_hd__inv_1
X269 net34 _270_ _090_ sky130_fd_sc_hd__nor2_1
X270 priority_q.write_ptr_2_ _269_ _270_ sky130_fd_sc_hd__xor2_1
X271 net1 _035_ net2 _116_ _269_ sky130_fd_sc_hd__nand4_1
X272 _268_ _089_ _263_ _262_ sky130_fd_sc_hd__mux2_2
X273 _267_ _268_ _265_ _264_ sky130_fd_sc_hd__mux2i_1
X274 _267_ _052_ _266_ _051_ sky130_fd_sc_hd__a21oi_1
X275 _266_ priority_count_0_ _030_ _050_ sky130_fd_sc_hd__a21o_1
X276 _047_ _010_ _265_ sky130_fd_sc_hd__nor2_1
X277 _047_ _013_ _264_ sky130_fd_sc_hd__nor2_1
X278 net34 _263_ priority_count_3_ sky130_fd_sc_hd__nor2b_1
X279 net34 priority_count_3_ _262_ sky130_fd_sc_hd__nor2_1
X280 _088_ _260_ _261_ net34 sky130_fd_sc_hd__a21oi_1
X281 _040_ net13 _113_ _261_ sky130_fd_sc_hd__nand3_1
X282 scheduler.priority_count_1_ _220_ _260_ sky130_fd_sc_hd__nand2_1
X283 net34 _259_ _087_ sky130_fd_sc_hd__nor2_1
X284 normal_q.write_ptr_2_ _258_ _259_ sky130_fd_sc_hd__xor2_1
X285 _117_ net1 _025_ _258_ net2 sky130_fd_sc_hd__nand4b_1
X286 _257_ _086_ _252_ _251_ sky130_fd_sc_hd__mux2_2
X287 _256_ _257_ _254_ _253_ sky130_fd_sc_hd__mux2i_1
X288 _256_ _034_ _255_ _033_ sky130_fd_sc_hd__a21oi_1
X289 _255_ normal_count_0_ _023_ _022_ sky130_fd_sc_hd__a21o_2
X290 _044_ _016_ _254_ sky130_fd_sc_hd__nor2_1
X291 _044_ _019_ _253_ sky130_fd_sc_hd__nor2_1
X292 net34 _252_ normal_count_3_ sky130_fd_sc_hd__nor2b_1
X293 normal_count_3_ net34 _251_ sky130_fd_sc_hd__nor2_1
X294 _192_ _250_ _085_ sky130_fd_sc_hd__nor2_1
X295 generated_token_7_ _249_ _250_ sky130_fd_sc_hd__xor2_1
X296 generated_token_5_ generated_token_6_ _190_ _195_ _249_ sky130_fd_sc_hd__nand4_1
X297 net34 _084_ _128_ sky130_fd_sc_hd__nor2b_1
X298 net34 _248_ _083_ sky130_fd_sc_hd__nor2_1
X299 normal_q.read_ptr_2_ _247_ _248_ sky130_fd_sc_hd__xor2_1
X300 _247_ _039_ _112_ _113_ _037_ sky130_fd_sc_hd__o211ai_1
X301 normal_q.write_ptr_1_ net34 normal_q.write_ptr_2_ _217_ _092_ sky130_fd_sc_hd__nor4_1
X302 normal_q.write_ptr_1_ net34 normal_q.write_ptr_2_ _241_ _093_ sky130_fd_sc_hd__nor4_1
X303 priority_q.write_ptr_1_ priority_q.write_ptr_2_ _244_ _101_ sky130_fd_sc_hd__nor3_1
X304 normal_q.write_ptr_2_ _217_ _246_ _094_ sky130_fd_sc_hd__nor3_1
X305 normal_q.write_ptr_2_ _241_ _246_ _095_ sky130_fd_sc_hd__nor3_1
X306 normal_q.write_ptr_1_ _246_ net34 sky130_fd_sc_hd__nand2b_1
X307 priority_q.write_ptr_0_ net34 _045_ _245_ _106_ sky130_fd_sc_hd__nor4_1
X308 normal_q.write_ptr_1_ _217_ net34 _096_ normal_q.write_ptr_2_ sky130_fd_sc_hd__nor4b_1
X309 _244_ _245_ _107_ sky130_fd_sc_hd__nor2_1
X310 priority_q.write_ptr_1_ priority_q.write_ptr_2_ _245_ sky130_fd_sc_hd__nand2_1
X311 net34 _045_ _244_ priority_q.write_ptr_0_ sky130_fd_sc_hd__or3b_1
X312 normal_q.write_ptr_1_ _241_ net34 _097_ normal_q.write_ptr_2_ sky130_fd_sc_hd__nor4b_1
X313 _217_ _243_ _098_ sky130_fd_sc_hd__nor2_1
X314 _241_ _243_ _099_ sky130_fd_sc_hd__nor2_1
X315 normal_q.write_ptr_2_ normal_q.write_ptr_1_ _243_ net34 sky130_fd_sc_hd__nand3b_1
X316 _117_ net1 normal_q.write_ptr_0_ _241_ net2 sky130_fd_sc_hd__nand4b_1
X317 net34 _240_ _082_ sky130_fd_sc_hd__nor2_1
X318 priority_q.read_ptr_2_ _239_ _240_ sky130_fd_sc_hd__xor2_1
X319 _031_ net4 _108_ _110_ _239_ sky130_fd_sc_hd__nand4_1
X320 priority_q.write_ptr_1_ priority_q.write_ptr_2_ _100_ _238_ sky130_fd_sc_hd__nor3b_1
X321 priority_q.write_ptr_0_ net34 _045_ _238_ sky130_fd_sc_hd__nor3_1
X322 _021_ _236_ net17 sky130_fd_sc_hd__xnor2_1
X323 _236_ _049_ _235_ _048_ sky130_fd_sc_hd__a21oi_1
X324 _235_ _024_ _006_ _041_ sky130_fd_sc_hd__a21o_1
X325 _007_ _049_ net16 sky130_fd_sc_hd__xor2_1
X326 normal_count_1_ _015_ sky130_fd_sc_hd__inv_1
X327 net34 _234_ _081_ sky130_fd_sc_hd__nor2_1
X328 priority_q.write_ptr_0_ _045_ _234_ sky130_fd_sc_hd__xor2_1
X329 net34 _233_ _080_ sky130_fd_sc_hd__nor2_1
X330 _045_ _233_ priority_q.write_ptr_1_ _036_ sky130_fd_sc_hd__mux2i_1
X331 net34 _232_ _079_ sky130_fd_sc_hd__nor2_1
X332 priority_q.read_ptr_0_ _046_ _232_ sky130_fd_sc_hd__xnor2_1
X333 net34 _231_ _078_ sky130_fd_sc_hd__nor2_1
X334 _046_ _231_ _032_ priority_q.read_ptr_1_ sky130_fd_sc_hd__mux2i_1
X335 net34 _230_ _077_ sky130_fd_sc_hd__nor2_1
X336 priority_count_0_ _047_ _230_ sky130_fd_sc_hd__xor2_1
X337 net34 _229_ _076_ sky130_fd_sc_hd__nor2_1
X338 _229_ _047_ priority_count_1_ _228_ sky130_fd_sc_hd__a21oi_1
X339 _047_ _012_ _228_ sky130_fd_sc_hd__nor2_1
X340 net34 _227_ _075_ sky130_fd_sc_hd__nor2_1
X341 _227_ _047_ priority_count_2_ _226_ sky130_fd_sc_hd__a21oi_1
X342 _047_ _225_ _226_ sky130_fd_sc_hd__nor2_1
X343 _011_ _052_ _225_ sky130_fd_sc_hd__xor2_1
X344 _074_ _222_ _223_ net34 sky130_fd_sc_hd__a21oi_1
X345 scheduler.priority_count_0_ _220_ _223_ sky130_fd_sc_hd__nand2_1
X346 net13 _221_ _222_ sky130_fd_sc_hd__nand2_1
X347 scheduler.priority_count_0_ _220_ _221_ sky130_fd_sc_hd__nor2_1
X348 _220_ normal_count_3_ normal_count_0_ net4 normal_count_1_ normal_count_2_ sky130_fd_sc_hd__o41ai_1
X349 net13 _039_ _127_ _112_ sky130_fd_sc_hd__a21oi_2
X350 _073_ _217_ _218_ net34 sky130_fd_sc_hd__a21oi_1
X351 normal_q.write_ptr_0_ _042_ _218_ sky130_fd_sc_hd__nand2_1
X352 normal_q.write_ptr_0_ _042_ _217_ sky130_fd_sc_hd__or2_1
X353 net34 _216_ _072_ sky130_fd_sc_hd__nor2_1
X354 _042_ _216_ normal_q.write_ptr_1_ _026_ sky130_fd_sc_hd__mux2i_1
X355 net34 _215_ _071_ sky130_fd_sc_hd__nor2_1
X356 normal_q.read_ptr_0_ _114_ _215_ sky130_fd_sc_hd__xnor2_1
X357 net34 _214_ _070_ sky130_fd_sc_hd__nor2_1
X358 _114_ _214_ _038_ normal_q.read_ptr_1_ sky130_fd_sc_hd__mux2i_1
X359 net34 _213_ _069_ sky130_fd_sc_hd__nor2_1
X360 _044_ normal_count_0_ _213_ sky130_fd_sc_hd__xor2_1
X361 net34 _212_ _068_ sky130_fd_sc_hd__nor2_1
X362 _212_ _044_ normal_count_1_ _211_ sky130_fd_sc_hd__a21oi_1
X363 _044_ _018_ _211_ sky130_fd_sc_hd__nor2_1
X364 net34 _210_ _067_ sky130_fd_sc_hd__nor2_1
X365 _210_ _044_ normal_count_2_ _209_ sky130_fd_sc_hd__a21oi_1
X366 _044_ _208_ _209_ sky130_fd_sc_hd__nor2_1
X367 _034_ _017_ _208_ sky130_fd_sc_hd__xor2_1
X368 _205_ _066_ _192_ sky130_fd_sc_hd__nand2b_1
X369 net1 generated_token_0_ _205_ sky130_fd_sc_hd__xnor2_1
X370 _192_ _204_ _065_ sky130_fd_sc_hd__nor2_1
X371 net1 _204_ _028_ generated_token_1_ sky130_fd_sc_hd__mux2i_1
X372 _192_ _203_ _064_ sky130_fd_sc_hd__nor2_1
X373 generated_token_2_ _202_ _203_ sky130_fd_sc_hd__xor2_1
X374 net1 _029_ _202_ sky130_fd_sc_hd__nand2_1
X375 _192_ _201_ _063_ sky130_fd_sc_hd__nor2_1
X376 generated_token_3_ _200_ _201_ sky130_fd_sc_hd__xor2_1
X377 generated_token_2_ _195_ _200_ sky130_fd_sc_hd__nand2_1
X378 _192_ _199_ _062_ sky130_fd_sc_hd__nor2_1
X379 generated_token_4_ _198_ _199_ sky130_fd_sc_hd__xor2_1
X380 net1 generated_token_2_ generated_token_3_ _029_ _198_ sky130_fd_sc_hd__nand4_1
X381 _192_ _197_ _061_ sky130_fd_sc_hd__nor2_1
X382 generated_token_5_ _196_ _197_ sky130_fd_sc_hd__xor2_1
X383 _190_ _195_ _196_ sky130_fd_sc_hd__nand2_1
X384 net1 generated_token_0_ generated_token_1_ _195_ sky130_fd_sc_hd__and3_1
X385 _192_ _194_ _060_ sky130_fd_sc_hd__nor2_1
X386 generated_token_6_ _193_ _194_ sky130_fd_sc_hd__xor2_1
X387 net1 generated_token_5_ _029_ _190_ _193_ sky130_fd_sc_hd__nand4_1
X388 _192_ generated_token_5_ generated_token_6_ net34 _190_ _191_ sky130_fd_sc_hd__a41o_1
X389 generated_token_7_ net1 _027_ _191_ sky130_fd_sc_hd__and3_1
X390 generated_token_2_ generated_token_3_ generated_token_4_ _190_ sky130_fd_sc_hd__and3_1
X391 _059_ _114_ _184_ _185_ _189_ net34 sky130_fd_sc_hd__a2111oi_2
X392 _189_ _005_ _186_ _188_ _111_ sky130_fd_sc_hd__a211oi_1
X393 _187_ _188_ _005_ sky130_fd_sc_hd__and2b_1
X394 _187_ priority_q.memory_1__0_ priority_q.memory_2__0_ priority_q.memory_3__0_ priority_q.memory_0__0_ _003_ _004_ sky130_fd_sc_hd__mux4_1
X395 _186_ priority_q.memory_5__0_ priority_q.memory_6__0_ priority_q.memory_7__0_ priority_q.memory_4__0_ _003_ _004_ sky130_fd_sc_hd__mux4_1
X396 net5 _128_ _185_ sky130_fd_sc_hd__nor2_1
X397 _000_ _184_ _183_ _182_ sky130_fd_sc_hd__mux2i_1
X398 _183_ normal_q.memory_3__0_ normal_q.memory_5__0_ normal_q.memory_7__0_ normal_q.memory_1__0_ _001_ _002_ sky130_fd_sc_hd__mux4_1
X399 _182_ normal_q.memory_2__0_ normal_q.memory_4__0_ normal_q.memory_6__0_ normal_q.memory_0__0_ _001_ _002_ sky130_fd_sc_hd__mux4_1
X400 _058_ _114_ _176_ _177_ _181_ net34 sky130_fd_sc_hd__a2111oi_2
X401 _181_ _005_ _178_ _180_ _111_ sky130_fd_sc_hd__a211oi_1
X402 _179_ _180_ _005_ sky130_fd_sc_hd__and2b_4
X403 _179_ priority_q.memory_1__1_ priority_q.memory_2__1_ priority_q.memory_3__1_ priority_q.memory_0__1_ _003_ _004_ sky130_fd_sc_hd__mux4_1
X404 _178_ priority_q.memory_5__1_ priority_q.memory_6__1_ priority_q.memory_7__1_ priority_q.memory_4__1_ _003_ _004_ sky130_fd_sc_hd__mux4_1
X405 net6 _128_ _177_ sky130_fd_sc_hd__nor2_1
X406 _000_ _176_ _175_ _174_ sky130_fd_sc_hd__mux2i_1
X407 _175_ normal_q.memory_3__1_ normal_q.memory_5__1_ normal_q.memory_7__1_ normal_q.memory_1__1_ _001_ _002_ sky130_fd_sc_hd__mux4_2
X408 _174_ normal_q.memory_2__1_ normal_q.memory_4__1_ normal_q.memory_6__1_ normal_q.memory_0__1_ _001_ _002_ sky130_fd_sc_hd__mux4_1
X409 _057_ _114_ _168_ _169_ _173_ net34 sky130_fd_sc_hd__a2111oi_2
X410 _173_ _005_ _170_ _172_ _111_ sky130_fd_sc_hd__a211oi_2
X411 _171_ _172_ _005_ sky130_fd_sc_hd__and2b_2
X412 _171_ priority_q.memory_1__2_ priority_q.memory_2__2_ priority_q.memory_3__2_ priority_q.memory_0__2_ _003_ _004_ sky130_fd_sc_hd__mux4_2
X413 _170_ priority_q.memory_5__2_ priority_q.memory_6__2_ priority_q.memory_7__2_ priority_q.memory_4__2_ _003_ _004_ sky130_fd_sc_hd__mux4_1
X414 net7 _128_ _169_ sky130_fd_sc_hd__nor2_1
X415 _000_ _168_ _167_ _166_ sky130_fd_sc_hd__mux2i_1
X416 _167_ normal_q.memory_3__2_ normal_q.memory_5__2_ normal_q.memory_7__2_ normal_q.memory_1__2_ _001_ _002_ sky130_fd_sc_hd__mux4_1
X417 _166_ normal_q.memory_2__2_ normal_q.memory_4__2_ normal_q.memory_6__2_ normal_q.memory_0__2_ _001_ _002_ sky130_fd_sc_hd__mux4_2
X418 _056_ _114_ _159_ _160_ _164_ net34 sky130_fd_sc_hd__a2111oi_2
X419 _164_ _005_ _161_ _163_ _111_ sky130_fd_sc_hd__a211oi_1
X420 _162_ _163_ _005_ sky130_fd_sc_hd__and2b_4
X421 _162_ priority_q.memory_1__3_ priority_q.memory_2__3_ priority_q.memory_3__3_ priority_q.memory_0__3_ _003_ _004_ sky130_fd_sc_hd__mux4_1
X422 _161_ priority_q.memory_5__3_ priority_q.memory_6__3_ priority_q.memory_7__3_ priority_q.memory_4__3_ _003_ _004_ sky130_fd_sc_hd__mux4_2
X423 net8 _128_ _160_ sky130_fd_sc_hd__nor2_1
X424 _000_ _159_ _158_ _157_ sky130_fd_sc_hd__mux2i_1
X425 _158_ normal_q.memory_3__3_ normal_q.memory_5__3_ normal_q.memory_7__3_ normal_q.memory_1__3_ _001_ _002_ sky130_fd_sc_hd__mux4_1
X426 _157_ normal_q.memory_2__3_ normal_q.memory_4__3_ normal_q.memory_6__3_ normal_q.memory_0__3_ _001_ _002_ sky130_fd_sc_hd__mux4_1
X427 _055_ _114_ _151_ _152_ _156_ net34 sky130_fd_sc_hd__a2111oi_2
X428 _156_ _005_ _153_ _155_ _111_ sky130_fd_sc_hd__a211oi_1
X429 _154_ _155_ _005_ sky130_fd_sc_hd__and2b_4
X430 _154_ priority_q.memory_1__4_ priority_q.memory_2__4_ priority_q.memory_3__4_ priority_q.memory_0__4_ _003_ _004_ sky130_fd_sc_hd__mux4_1
X431 _153_ priority_q.memory_5__4_ priority_q.memory_6__4_ priority_q.memory_7__4_ priority_q.memory_4__4_ _003_ _004_ sky130_fd_sc_hd__mux4_1
X432 net9 _128_ _152_ sky130_fd_sc_hd__nor2_1
X433 _000_ _151_ _150_ _149_ sky130_fd_sc_hd__mux2i_1
X434 _150_ normal_q.memory_3__4_ normal_q.memory_5__4_ normal_q.memory_7__4_ normal_q.memory_1__4_ _001_ _002_ sky130_fd_sc_hd__mux4_1
X435 _149_ normal_q.memory_2__4_ normal_q.memory_4__4_ normal_q.memory_6__4_ normal_q.memory_0__4_ _001_ _002_ sky130_fd_sc_hd__mux4_1
X436 _054_ _114_ _143_ _144_ _148_ net34 sky130_fd_sc_hd__a2111oi_2
X437 _148_ _005_ _145_ _147_ _111_ sky130_fd_sc_hd__a211oi_2
X438 _005_ _147_ _146_ sky130_fd_sc_hd__nor2b_1
X439 _146_ priority_q.memory_1__5_ priority_q.memory_2__5_ priority_q.memory_3__5_ priority_q.memory_0__5_ _003_ _004_ sky130_fd_sc_hd__mux4_2
X440 _145_ priority_q.memory_5__5_ priority_q.memory_6__5_ priority_q.memory_7__5_ priority_q.memory_4__5_ _003_ _004_ sky130_fd_sc_hd__mux4_1
X441 net10 _128_ _144_ sky130_fd_sc_hd__nor2_1
X442 _000_ _143_ _142_ _141_ sky130_fd_sc_hd__mux2i_1
X443 _142_ normal_q.memory_3__5_ normal_q.memory_5__5_ normal_q.memory_7__5_ normal_q.memory_1__5_ _001_ _002_ sky130_fd_sc_hd__mux4_1
X444 _141_ normal_q.memory_2__5_ normal_q.memory_4__5_ normal_q.memory_6__5_ normal_q.memory_0__5_ _001_ _002_ sky130_fd_sc_hd__mux4_1
X445 _053_ _114_ _126_ _130_ _139_ net34 sky130_fd_sc_hd__a2111oi_2
X446 _139_ _005_ _136_ _138_ _111_ sky130_fd_sc_hd__a211oi_2
X447 _005_ _138_ _137_ sky130_fd_sc_hd__nor2b_1
X448 _137_ priority_q.memory_1__6_ priority_q.memory_2__6_ priority_q.memory_3__6_ priority_q.memory_0__6_ _003_ _004_ sky130_fd_sc_hd__mux4_2
X449 _136_ priority_q.memory_5__6_ priority_q.memory_6__6_ priority_q.memory_7__6_ priority_q.memory_4__6_ _003_ _004_ sky130_fd_sc_hd__mux4_1
X450 net11 _128_ _130_ sky130_fd_sc_hd__nor2_1
X451 _128_ _108_ _127_ net4 sky130_fd_sc_hd__o21a_1
X452 normal_count_3_ normal_count_0_ normal_count_1_ normal_count_2_ _127_ sky130_fd_sc_hd__or4_1
X453 _000_ _126_ _124_ _123_ sky130_fd_sc_hd__mux2i_1
X454 _124_ normal_q.memory_3__6_ normal_q.memory_5__6_ normal_q.memory_7__6_ normal_q.memory_1__6_ _001_ _002_ sky130_fd_sc_hd__mux4_1
X455 _123_ normal_q.memory_2__6_ normal_q.memory_4__6_ normal_q.memory_6__6_ normal_q.memory_0__6_ _001_ _002_ sky130_fd_sc_hd__mux4_1
X456 _019_ _016_ sky130_fd_sc_hd__inv_1
X457 _013_ _010_ sky130_fd_sc_hd__inv_1
X458 net18 _021_ _118_ _020_ sky130_fd_sc_hd__a21o_1
X459 _118_ _007_ _049_ _048_ sky130_fd_sc_hd__a21o_1
X460 _117_ net1 _042_ net2 sky130_fd_sc_hd__nand3b_2
X461 normal_count_0_ normal_count_1_ normal_count_2_ _117_ normal_count_3_ sky130_fd_sc_hd__or4b_4
X462 net1 net2 _116_ _045_ sky130_fd_sc_hd__nand3_2
X463 priority_count_0_ priority_count_1_ priority_count_2_ _116_ priority_count_3_ sky130_fd_sc_hd__or4b_1
X464 normal_count_0_ _014_ sky130_fd_sc_hd__inv_1
X465 _114_ _039_ _112_ _113_ sky130_fd_sc_hd__o21a_2
X466 _113_ normal_count_3_ normal_count_0_ net4 normal_count_1_ normal_count_2_ sky130_fd_sc_hd__o41a_1
X467 priority_count_0_ priority_count_1_ priority_count_2_ priority_count_3_ _112_ sky130_fd_sc_hd__nor4_1
X468 priority_count_0_ _008_ sky130_fd_sc_hd__inv_1
X469 _111_ _046_ sky130_fd_sc_hd__inv_2
X470 net4 _108_ _110_ _111_ sky130_fd_sc_hd__nand3_4
X471 _110_ normal_count_3_ normal_count_0_ _039_ normal_count_1_ normal_count_2_ sky130_fd_sc_hd__o41ai_4
X472 priority_count_0_ priority_count_1_ priority_count_2_ priority_count_3_ _108_ sky130_fd_sc_hd__or4_4

************************
* end of SPICE netlist *
************************
